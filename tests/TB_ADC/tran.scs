//-----------------------------------------------------------------
// OPTIONS
//-----------------------------------------------------------------

global 0

simulatorOptions options reltol=1e-6 vabstol=1e-6 save=selected \
iabstol=1e-12 gmin=1e-15 redefinedparams=warning digits=7 cols=80 \
pivrel=1e-3  checklimitdest=both

//-----------------------------------------------------------------
// PARAMETERS
//-----------------------------------------------------------------

#ifdef DEBUG
parameters nbpt=16
#else
parameters nbpt=64
#endif

parameters cfs=8M vamp=0.6 tshift=10n td=3/cfs fbin=2  \
 blk_pwell=vdda blk_nwell=0 tend=(nbpt/cfs + 25/cfs + td + tshift)

//-----------------------------------------------------------------
// DUT
//-----------------------------------------------------------------

ahdl_include "$PROJECT/testbench/AGNEZA_SAR9B_TB/mdl_twos_complement_dac12/veriloga/veriloga.va"
ahdl_include "$PROJECT/testbench/AGNEZA_SAR9B_TB/mdl_supply/veriloga/veriloga.va"

//-----------------------------------------------------------------
// FORCE
//-----------------------------------------------------------------

//-----------------------------------------------------------------
// ANALYSIS
//-----------------------------------------------------------------
tran tran start=0 stop=tend method=gear2only compression=yes

//-----------------------------------------------------------------
// ANALYSIS
//-----------------------------------------------------------------

save XDUT:AVDD_CORE
save XDUT:VREF
save XDUT:AVDD_ADC
save RO
save DISABLE_CAL_CV
