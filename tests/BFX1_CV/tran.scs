//-----------------------------------------------------------------
// OPTIONS
//-----------------------------------------------------------------

global 0

simulatorOptions options reltol=1e-6 vabstol=1e-6 save=selected \
iabstol=1e-12 gmin=1e-15 redefinedparams=warning digits=7 cols=80 \
pivrel=1e-3  checklimitdest=both

//-----------------------------------------------------------------
// PARAMETERS
//-----------------------------------------------------------------
parameters cfs=16M

//-----------------------------------------------------------------
// DUT
//-----------------------------------------------------------------
include "../dut.scs"

//-----------------------------------------------------------------
// FORCE
//-----------------------------------------------------------------

//-----------------------------------------------------------------
// ANALYSIS
//-----------------------------------------------------------------
tran tran start=0 stop=1u

//save A Y
