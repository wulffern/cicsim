//-----------------------------------------------------------------
// DEVICE UNDER TEST
//-----------------------------------------------------------------
xdut (A AVDD AVSS BULKN BULKP Y ) BFX1_CV

// Force A
vpulse_a (A 0 ) vsource type=pulse val0=0 vall=vdda period=1/cfs rise=50p fall=50p width=1/cfs/2

// Force AVDD
vdc_avdd (AVDD 0 ) vsource type=dc dc=vdda

// Force AVSS
vdc_avss (AVSS 0 ) vsource type=dc dc=0

// Force BULKN
vdc_bulkn (BULKN 0 ) vsource type=dc dc=0

// Force BULKP
vdc_bulkp (BULKP 0 ) vsource type=dc dc=vdda

// Force Y
cy (Y 0) capacitor c=10f
