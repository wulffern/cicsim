;;;;;;;;;;;;;;;;;;;;;;;;;;;;;;;;;;;;;;;;;;;;;;;;;;;;;;;;;;;;;;;;;;;;;;
;;        Copyright (c) 2020 Carsten Wulff Software, Norway
;; ;;;;;;;;;;;;;;;;;;;;;;;;;;;;;;;;;;;;;;;;;;;;;;;;;;;;;;;;;;;;;;;;;;;
;; Created       : wulff at 2020-11-20
;; ;;;;;;;;;;;;;;;;;;;;;;;;;;;;;;;;;;;;;;;;;;;;;;;;;;;;;;;;;;;;;;;;;;;
;;  The MIT License (MIT)
;;
;;  Permission is hereby granted, free of charge, to any person obtaining a copy
;;  of this software and associated documentation files (the "Software"), to deal
;;  in the Software without restriction, including without limitation the rights
;;  to use, copy, modify, merge, publish, distribute, sublicense, and/or sell
;;  copies of the Software, and to permit persons to whom the Software is
;;  furnished to do so, subject to the following conditions:
;;
;;  The above copyright notice and this permission notice shall be included in all
;;  copies or substantial portions of the Software.
;;
;;  THE SOFTWARE IS PROVIDED "AS IS", WITHOUT WARRANTY OF ANY KIND, EXPRESS OR
;;  IMPLIED, INCLUDING BUT NOT LIMITED TO THE WARRANTIES OF MERCHANTABILITY,
;;  FITNESS FOR A PARTICULAR PURPOSE AND NONINFRINGEMENT. IN NO EVENT SHALL THE
;;  AUTHORS OR COPYRIGHT HOLDERS BE LIABLE FOR ANY CLAIM, DAMAGES OR OTHER
;;  LIABILITY, WHETHER IN AN ACTION OF CONTRACT, TORT OR OTHERWISE, ARISING FROM,
;;  OUT OF OR IN CONNECTION WITH THE SOFTWARE OR THE USE OR OTHER DEALINGS IN THE
;;  SOFTWARE.
;;
;;;;;;;;;;;;;;;;;;;;;;;;;;;;;;;;;;;;;;;;;;;;;;;;;;;;;;;;;;;;;;;;;;;;;;

;cicResultsFile = "output_tran/results.yaml"
;cicResultsDir = "/home/wulff/pro/cicsim/tests/AGNEZA_SAR9B_GF130N/BFX1_CV/output_tran/tran_SchGtMttRtCtTtVtDtBt.psf"
ocnSetXLMode()
simulator('spectre)

w_y = v("Y" ?result "tran-tran" ?resultsDir cicResultsDir)

cfs = 16M
t_p2 = 1/cfs/2

t_low = 50n
t_high = 80n
t_low_2  = 100n

t_rise = riseTime(w_y t_low t t_high t 10 90 nil "time")
t_fall = fallTime(w_y t_high t t_low_2 t 10 90 nil "time")

fo = outfile(cicResultsFile)
ocnPrint(?output fo ?numberNotation "scientific"  ?numSpaces 0 "t_fall:" t_fall)
ocnPrint(?output fo ?numberNotation "scientific"  ?numSpaces 0 "t_rise:" t_rise)
close(fo)
