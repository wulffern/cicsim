//-----------------------------------------------------------------
// OPTIONS
//-----------------------------------------------------------------

global 0

simulatorOptions options reltol=1e-6 vabstol=1e-6 save=selected \
iabstol=1e-12 gmin=1e-15 redefinedparams=warning digits=7 cols=80 \
pivrel=1e-3  checklimitdest=both

//-----------------------------------------------------------------
// PARAMETERS
//-----------------------------------------------------------------
parameters avdd=1.2 cfs=16M

//-----------------------------------------------------------------
// DUT
//-----------------------------------------------------------------
include "../dut.scs"

//-----------------------------------------------------------------
// FORCE
//-----------------------------------------------------------------

vsrc1 (A 0) vsource type=pulse val0=0 val1=avdd period=1/cfs rise=50p fall=50p width=1/cfs/2

//-----------------------------------------------------------------
// ANALYSIS
//-----------------------------------------------------------------

tran tran start=0 stop=1u
